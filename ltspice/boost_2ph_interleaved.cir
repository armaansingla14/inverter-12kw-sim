* Two-phase interleaved boost 400 V -> 700 V, 12 kW, 50 kHz per phase (LTspice syntax, not run here)
.param Vin=400 D=0.43 fsw=50k L=400u
Vin in 0 {Vin}
V1 g1 0 PULSE(0 15 0 10n 10n {D/fsw} {1/fsw})
V2 g2 0 PULSE(0 15 {0.5/fsw} 10n 10n {D/fsw} {1/fsw})
L1 in sw1 {L} Rser=25m
L2 in sw2 {L} Rser=25m
S1 sw1 0 g1 0 SWM
S2 sw2 0 g2 0 SWM
D1 sw1 out DSBD
D2 sw2 out DSBD
Cout out 0 470u Rser=5m IC=700
Rload out 0 40.83
.model SWM SW(Ron=60m Roff=1Meg Vt=7.5 Vh=-1)
.model DSBD D(Ron=35m Vfwd=0.9 Roff=1Meg)
.tran 0 30m 25m 20n UIC
.meas TRAN Vout AVG V(out) FROM 25m TO 30m
.meas TRAN Iin_pp PP I(Vin) FROM 29m TO 30m
.end
